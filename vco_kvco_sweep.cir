* 3-Stage CMOS Ring Oscillator VCO - KVCO Curve Measurement
* 掃描控制電壓Vctrl來測量頻率變化,產生KVCO曲線

* PDK 路徑
.lib /opt/pdk/sky130A/libs.tech/ngspice/sky130.lib.spice tt

* Power Supply
Vdd vdd 0 DC 1.8

* Control Voltage (will be swept)
Vctrl vctrl 0 DC 0.9

* ========== Inverter 1 with Control Transistors ==========
* PMOS control transistor (連接Vdd到反向器電源)
XM1_ctrl_p vdd_inv1 vctrl vdd vdd sky130_fd_pr__pfet_01v8 L=0.15 W=1.0

* NMOS control transistor (連接反向器接地到GND)
XM1_ctrl_n gnd_inv1 vctrl 0 0 sky130_fd_pr__nfet_01v8 L=0.15 W=0.5

* Inverter 1 core (NFET and PFET)
XM1_n out1 in1 gnd_inv1 0 sky130_fd_pr__nfet_01v8 L=0.15 W=0.42
XM1_p out1 in1 vdd_inv1 vdd sky130_fd_pr__pfet_01v8 L=0.15 W=0.84

* ========== Inverter 2 with Control Transistors ==========
* PMOS control transistor
XM2_ctrl_p vdd_inv2 vctrl vdd vdd sky130_fd_pr__pfet_01v8 L=0.15 W=1.0

* NMOS control transistor
XM2_ctrl_n gnd_inv2 vctrl 0 0 sky130_fd_pr__nfet_01v8 L=0.15 W=0.5

* Inverter 2 core
XM2_n out2 out1 gnd_inv2 0 sky130_fd_pr__nfet_01v8 L=0.15 W=0.42
XM2_p out2 out1 vdd_inv2 vdd sky130_fd_pr__pfet_01v8 L=0.15 W=0.84

* ========== Inverter 3 with Control Transistors (feedback to input) ==========
* PMOS control transistor
XM3_ctrl_p vdd_inv3 vctrl vdd vdd sky130_fd_pr__pfet_01v8 L=0.15 W=1.0

* NMOS control transistor
XM3_ctrl_n gnd_inv3 vctrl 0 0 sky130_fd_pr__nfet_01v8 L=0.15 W=0.5

* Inverter 3 core (forming ring)
XM3_n in1 out2 gnd_inv3 0 sky130_fd_pr__nfet_01v8 L=0.15 W=0.42
XM3_p in1 out2 vdd_inv3 vdd sky130_fd_pr__pfet_01v8 L=0.15 W=0.84

* Initial condition to start oscillation
.ic v(in1)=0 v(out1)=1.8 v(out2)=0

* Control block - 掃描控制電壓
.control
set hcopydevtype=postscript

* 建立結果檔案
echo "Vctrl(V),Frequency(GHz),Period(ns)" > vco_kvco_results.csv

echo ""
echo "==================== 開始KVCO掃描 ===================="
echo ""

* 掃描控制電壓從 0.1V 到 1.7V,間隔 0.05V
foreach vctrl_val 0.1 0.15 0.2 0.25 0.3 0.35 0.4 0.45 0.5 0.55 0.6 0.65 0.7 0.75 0.8 0.85 0.9 0.95 1.0 1.05 1.1 1.15 1.2 1.25 1.3 1.35 1.4 1.45 1.5 1.55 1.6 1.65 1.7
  alter Vctrl = $vctrl_val
  echo "正在模擬 Vctrl = $vctrl_val V..."

  * 執行暫態分析 (較長時間以確保穩定振盪)
  tran 0.1n 300n

  * 量測週期和頻率 (使用後段的週期避免初始不穩定)
  meas tran t1 WHEN v(in1)=0.9 RISE=10
  meas tran t2 WHEN v(in1)=0.9 RISE=11

  * 檢查量測是否成功
  if t2 > t1
    let period_ns = (t2-t1)*1e9
    let freq_GHz = 1/(t2-t1)/1e9

    * 將結果寫入檔案
    echo "$vctrl_val,$&freq_GHz,$&period_ns" >> vco_kvco_results.csv
  else
    echo "$vctrl_val,0,0" >> vco_kvco_results.csv
    echo "  警告: 在 Vctrl = $vctrl_val V 時無法量測到穩定振盪"
  end

  * 重置電路
  reset
end

echo ""
echo "==================== KVCO掃描完成 ===================="
echo "結果已儲存至: vco_kvco_results.csv"
echo "請使用Python腳本繪製KVCO曲線圖"
echo "================================================="
echo ""
quit
.endc

.end
