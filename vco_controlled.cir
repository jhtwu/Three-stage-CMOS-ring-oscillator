* 3-Stage CMOS Ring Oscillator VCO with Voltage Control
* 基於new_vco.odt的電壓控制環形振盪器設計
* 每個反向器加入PMOS/NMOS控制電晶體來調整電源供應

* PDK 路徑
.lib /opt/pdk/sky130A/libs.tech/ngspice/sky130.lib.spice tt

* Power Supply
Vdd vdd 0 DC 1.8

* Control Voltage (調整此電壓來控制振盪頻率)
Vctrl vctrl 0 DC 0.9

* ========== Inverter 1 with Control Transistors ==========
* PMOS control transistor (連接Vdd到反向器電源)
XM1_ctrl_p vdd_inv1 vctrl vdd vdd sky130_fd_pr__pfet_01v8 L=0.15 W=1.0

* NMOS control transistor (連接反向器接地到GND)
XM1_ctrl_n gnd_inv1 vctrl 0 0 sky130_fd_pr__nfet_01v8 L=0.15 W=0.5

* Inverter 1 core (NFET and PFET)
XM1_n out1 in1 gnd_inv1 0 sky130_fd_pr__nfet_01v8 L=0.15 W=0.42
XM1_p out1 in1 vdd_inv1 vdd sky130_fd_pr__pfet_01v8 L=0.15 W=0.84

* ========== Inverter 2 with Control Transistors ==========
* PMOS control transistor
XM2_ctrl_p vdd_inv2 vctrl vdd vdd sky130_fd_pr__pfet_01v8 L=0.15 W=1.0

* NMOS control transistor
XM2_ctrl_n gnd_inv2 vctrl 0 0 sky130_fd_pr__nfet_01v8 L=0.15 W=0.5

* Inverter 2 core
XM2_n out2 out1 gnd_inv2 0 sky130_fd_pr__nfet_01v8 L=0.15 W=0.42
XM2_p out2 out1 vdd_inv2 vdd sky130_fd_pr__pfet_01v8 L=0.15 W=0.84

* ========== Inverter 3 with Control Transistors (feedback to input) ==========
* PMOS control transistor
XM3_ctrl_p vdd_inv3 vctrl vdd vdd sky130_fd_pr__pfet_01v8 L=0.15 W=1.0

* NMOS control transistor
XM3_ctrl_n gnd_inv3 vctrl 0 0 sky130_fd_pr__nfet_01v8 L=0.15 W=0.5

* Inverter 3 core (forming ring)
XM3_n in1 out2 gnd_inv3 0 sky130_fd_pr__nfet_01v8 L=0.15 W=0.42
XM3_p in1 out2 vdd_inv3 vdd sky130_fd_pr__pfet_01v8 L=0.15 W=0.84

* Initial condition to start oscillation
.ic v(in1)=0 v(out1)=1.8 v(out2)=0

* Transient Analysis (模擬 300ns,每 0.1ns 記錄一次)
.tran 0.1n 300n

* Control block
.control
run

* 繪製波形
plot v(in1) v(out1) v(out2)
plot v(vctrl)

* 寫入原始資料
write vco_controlled.raw

* 量測振盪週期和頻率
meas tran period TRIG v(in1) VAL=0.9 RISE=10 TARG v(in1) VAL=0.9 RISE=11
let freq_MHz = 1/period/1e6
print period freq_MHz

echo ""
echo "==================== 模擬結果 ===================="
echo "控制電壓 Vctrl = 0.9V"
print period
print freq_MHz
echo "================================================="
echo ""

.endc

.end
