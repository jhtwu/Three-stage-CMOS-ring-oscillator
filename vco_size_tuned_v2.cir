* 3-Stage CMOS Ring Oscillator VCO - Size Tuned Version 2
* 尺寸調整版本2: 減小PMOS控制，加大NMOS控制
* 讓NMOS主導控制特性

* PDK 路徑
.lib /opt/pdk/sky130A/libs.tech/ngspice/sky130.lib.spice tt

* Power Supply
Vdd vdd 0 DC 1.8

* Control Voltage
Vctrl vctrl 0 DC 0.9

* ========== Inverter 1 with Tuned Control Transistors ==========
* PMOS控制電晶體 (減小到0.2um，減弱影響力)
XM1_ctrl_p vdd_inv1 vctrl vdd vdd sky130_fd_pr__pfet_01v8 L=0.15 W=0.2

* NMOS控制電晶體 (加大到3.0um，增強影響力)
XM1_ctrl_n gnd_inv1 vctrl 0 0 sky130_fd_pr__nfet_01v8 L=0.15 W=3.0

* Inverter 1 core
XM1_n out1 in1 gnd_inv1 0 sky130_fd_pr__nfet_01v8 L=0.15 W=0.42
XM1_p out1 in1 vdd_inv1 vdd sky130_fd_pr__pfet_01v8 L=0.15 W=0.84

* ========== Inverter 2 with Tuned Control Transistors ==========
* PMOS控制電晶體
XM2_ctrl_p vdd_inv2 vctrl vdd vdd sky130_fd_pr__pfet_01v8 L=0.15 W=0.2

* NMOS控制電晶體
XM2_ctrl_n gnd_inv2 vctrl 0 0 sky130_fd_pr__nfet_01v8 L=0.15 W=3.0

* Inverter 2 core
XM2_n out2 out1 gnd_inv2 0 sky130_fd_pr__nfet_01v8 L=0.15 W=0.42
XM2_p out2 out1 vdd_inv2 vdd sky130_fd_pr__pfet_01v8 L=0.15 W=0.84

* ========== Inverter 3 with Tuned Control Transistors ==========
* PMOS控制電晶體
XM3_ctrl_p vdd_inv3 vctrl vdd vdd sky130_fd_pr__pfet_01v8 L=0.15 W=0.2

* NMOS控制電晶體
XM3_ctrl_n gnd_inv3 vctrl 0 0 sky130_fd_pr__nfet_01v8 L=0.15 W=3.0

* Inverter 3 core
XM3_n in1 out2 gnd_inv3 0 sky130_fd_pr__nfet_01v8 L=0.15 W=0.42
XM3_p in1 out2 vdd_inv3 vdd sky130_fd_pr__pfet_01v8 L=0.15 W=0.84

* Initial condition
.ic v(in1)=0 v(out1)=1.8 v(out2)=0

* Transient Analysis
.tran 0.1n 300n

* Control block
.control
run
plot v(in1) v(out1) v(out2)
write vco_size_tuned_v2.raw

meas tran period TRIG v(in1) VAL=0.9 RISE=10 TARG v(in1) VAL=0.9 RISE=11
let freq_MHz = 1/period/1e6

echo ""
echo "==================== V2: NMOS主導 ===================="
echo "PMOS控制: W=0.2um, NMOS控制: W=3.0um"
echo "控制電壓 Vctrl = 0.9V"
print period freq_MHz
echo "====================================================="
echo ""
.endc

.end
