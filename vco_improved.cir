* 3-Stage CMOS Ring Oscillator VCO - Improved Design
* 改良版VCO，使用starved inverter設計產生單調遞減的KVCO曲線
* 控制電晶體改為電流源形式，當Vctrl增加時頻率降低

* PDK 路徑
.lib /opt/pdk/sky130A/libs.tech/ngspice/sky130.lib.spice tt

* Power Supply
Vdd vdd 0 DC 1.8

* Control Voltage (調整此電壓來控制振盪頻率)
* Vctrl越高 → 電流越小 → 頻率越低
Vctrl vctrl 0 DC 0.9

* ========== Inverter 1 with Current-Starved Control ==========
* 控制電晶體作為電流源，限制反向器的驅動電流
* NMOS電流鏡（限制下拉電流）
XM1_ctrl_n out1 vctrl 0 0 sky130_fd_pr__nfet_01v8 L=0.15 W=2.0

* 反向器核心
XM1_p out1 in1 vdd vdd sky130_fd_pr__pfet_01v8 L=0.15 W=1.0
XM1_n n1 in1 0 0 sky130_fd_pr__nfet_01v8 L=0.15 W=0.5

* ========== Inverter 2 with Current-Starved Control ==========
XM2_ctrl_n out2 vctrl 0 0 sky130_fd_pr__nfet_01v8 L=0.15 W=2.0

XM2_p out2 out1 vdd vdd sky130_fd_pr__pfet_01v8 L=0.15 W=1.0
XM2_n n2 out1 0 0 sky130_fd_pr__nfet_01v8 L=0.15 W=0.5

* ========== Inverter 3 with Current-Starved Control (feedback) ==========
XM3_ctrl_n in1 vctrl 0 0 sky130_fd_pr__nfet_01v8 L=0.15 W=2.0

XM3_p in1 out2 vdd vdd sky130_fd_pr__pfet_01v8 L=0.15 W=1.0
XM3_n n3 out2 0 0 sky130_fd_pr__nfet_01v8 L=0.15 W=0.5

* Initial condition to start oscillation
.ic v(in1)=0 v(out1)=1.8 v(out2)=0

* Transient Analysis
.tran 0.1n 300n

* Control block
.control
run

* 繪製波形
plot v(in1) v(out1) v(out2)
plot v(vctrl)

* 寫入原始資料
write vco_improved.raw

* 量測振盪週期和頻率
meas tran period TRIG v(in1) VAL=0.9 RISE=10 TARG v(in1) VAL=0.9 RISE=11
let freq_MHz = 1/period/1e6
print period freq_MHz

echo ""
echo "==================== 模擬結果 ===================="
echo "控制電壓 Vctrl = 0.9V"
print period
print freq_MHz
echo "================================================="
echo ""

.endc

.end
