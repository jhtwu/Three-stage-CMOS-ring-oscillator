* 3-Stage CMOS Ring Oscillator VCO - Based on circuit.jpg - KVCO Sweep
* Vctrl 只控制 PMOS (上方控制電晶體)

* PDK 路徑
.lib /opt/pdk/sky130A/libs.tech/ngspice/sky130.lib.spice tt

* Power Supply
Vdd vdd 0 DC 1.8

* Control Voltage (將被掃描)
Vctrl vctrl 0 DC 0.9

* ========== Inverter 1 ==========
* 上方 PMOS 控制電晶體 (Vctrl 控制)
XM1_ctrl_p vdd_inv1 vctrl vdd vdd sky130_fd_pr__pfet_01v8 L=0.15 W=2.0

* 標準反向器 PMOS
XM1_p out1 in1 vdd_inv1 vdd sky130_fd_pr__pfet_01v8 L=0.15 W=0.84

* 標準反向器 NMOS (直接接地)
XM1_n out1 in1 0 0 sky130_fd_pr__nfet_01v8 L=0.15 W=0.42

* ========== Inverter 2 ==========
* 上方 PMOS 控制電晶體
XM2_ctrl_p vdd_inv2 vctrl vdd vdd sky130_fd_pr__pfet_01v8 L=0.15 W=2.0

* 標準反向器
XM2_p out2 out1 vdd_inv2 vdd sky130_fd_pr__pfet_01v8 L=0.15 W=0.84
XM2_n out2 out1 0 0 sky130_fd_pr__nfet_01v8 L=0.15 W=0.42

* ========== Inverter 3 ==========
* 上方 PMOS 控制電晶體
XM3_ctrl_p vdd_inv3 vctrl vdd vdd sky130_fd_pr__pfet_01v8 L=0.15 W=2.0

* 標準反向器
XM3_p in1 out2 vdd_inv3 vdd sky130_fd_pr__pfet_01v8 L=0.15 W=0.84
XM3_n in1 out2 0 0 sky130_fd_pr__nfet_01v8 L=0.15 W=0.42

* Initial condition
.ic v(in1)=0 v(out1)=1.8 v(out2)=0

* Control block - KVCO Sweep
.control
set wr_singlescale
set wr_vecnames

* 創建 CSV 檔案
echo "Vctrl(V),Frequency(GHz)" > vco_kvco_circuit_jpg_results.csv

* 掃描控制電壓
foreach vctrl_val 0.1 0.15 0.2 0.25 0.3 0.35 0.4 0.45 0.5 0.55 0.6 0.65 0.7 0.75 0.8 0.85 0.9 0.95 1.0 1.05 1.1 1.15 1.2 1.25 1.3 1.35 1.4 1.45 1.5 1.55 1.6 1.65 1.7
  alter Vctrl = $vctrl_val

  tran 0.1n 300n

  * 量測頻率
  meas tran t1 WHEN v(in1)=0.9 RISE=10
  meas tran t2 WHEN v(in1)=0.9 RISE=11

  * 計算頻率並寫入 CSV
  let period = t2 - t1
  let freq_GHz = 1/period/1e9
  echo "$vctrl_val,$&freq_GHz" >> vco_kvco_circuit_jpg_results.csv
  echo "Vctrl = $vctrl_val V: Freq = $&freq_GHz GHz"
end

echo ""
echo "KVCO 掃描完成！結果已儲存至 vco_kvco_circuit_jpg_results.csv"
echo ""

quit
.endc

.end
