* 3-Stage CMOS Ring Oscillator VCO - Based on circuit.jpg
* Vctrl 只控制 PMOS (上方控制電晶體)
* 下方使用 PMOS current source (gate 接 Vdd)

* PDK 路徑
.lib /opt/pdk/sky130A/libs.tech/ngspice/sky130.lib.spice tt

* Power Supply
Vdd vdd 0 DC 1.8

* Control Voltage (只控制 PMOS)
Vctrl vctrl 0 DC 0.9

* ========== Inverter 1 ==========
* 上方 PMOS 控制電晶體 (Vctrl 控制)
XM1_ctrl_p vdd_inv1 vctrl vdd vdd sky130_fd_pr__pfet_01v8 L=0.15 W=2.0

* 標準反向器 PMOS
XM1_p out1 in1 vdd_inv1 vdd sky130_fd_pr__pfet_01v8 L=0.15 W=0.84

* 標準反向器 NMOS (直接接地)
XM1_n out1 in1 0 0 sky130_fd_pr__nfet_01v8 L=0.15 W=0.42

* ========== Inverter 2 ==========
* 上方 PMOS 控制電晶體
XM2_ctrl_p vdd_inv2 vctrl vdd vdd sky130_fd_pr__pfet_01v8 L=0.15 W=2.0

* 標準反向器
XM2_p out2 out1 vdd_inv2 vdd sky130_fd_pr__pfet_01v8 L=0.15 W=0.84
XM2_n out2 out1 0 0 sky130_fd_pr__nfet_01v8 L=0.15 W=0.42

* ========== Inverter 3 ==========
* 上方 PMOS 控制電晶體
XM3_ctrl_p vdd_inv3 vctrl vdd vdd sky130_fd_pr__pfet_01v8 L=0.15 W=2.0

* 標準反向器
XM3_p in1 out2 vdd_inv3 vdd sky130_fd_pr__pfet_01v8 L=0.15 W=0.84
XM3_n in1 out2 0 0 sky130_fd_pr__nfet_01v8 L=0.15 W=0.42

* Initial condition
.ic v(in1)=0 v(out1)=1.8 v(out2)=0

* Transient Analysis
.tran 0.1n 300n

* Control block
.control
run
plot v(in1) v(out1) v(out2)
write vco_circuit_jpg.raw

meas tran period TRIG v(in1) VAL=0.9 RISE=10 TARG v(in1) VAL=0.9 RISE=11
let freq_MHz = 1/period/1e6

echo ""
echo "============== VCO (circuit.jpg) =============="
echo "控制方式: Vctrl 只控制 PMOS"
echo "控制電壓 Vctrl = 0.9V"
print period freq_MHz
echo "==============================================="
echo ""
.endc

.end
